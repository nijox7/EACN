// AMS netlist generated by the AMS Unified netlister
// IC subversion:  IC6.1.8-64b.500.36
// IUS version: 15.20-s074
// Copyright(C) 2005-2009, Cadence Design Systems, Inc
// User: galayko Pid: 19387
// Design library name: project_EACN_SESI
// Design cell name: ADC_SAR
// Design view name: config
// Solver: Spectre

`include "disciplines.vams"
`include "userDisciplines.vams"
// HDL file - project_EACN_SESI, control, behavioral.
// Library - project_EACN_SESI, Cell - SWITCH, View - schematic
// LAST TIME SAVED: Mar 19 10:15:30 2026
// NETLIST TIME: Mar 19 10:59:38 2026

`worklib project_EACN_SESI
`view schematic

`timescale 1ns / 1ps
(* cds_ams_schematic *)

module SWITCH (SW1, SW2, SW_CLK);
input  SW_CLK;
inout  SW1, SW2;
wire net04;
INVX1 I39 (.Q( net04 ), .A( SW_CLK ));
modp #(.w(1e-06), .l(3.5e-07), .as(8.5e-13), .ad(8.5e-13), .ps(2.7e-06), .pd(2.7e-06), .nrd(0.5), .nrs(0.5), .ng(1)) MP5 (SW2, net04, SW1, cds_globals.\vdd! );
modn #(.w(5e-07), .l(3.5e-07), .as(4.25e-13), .ad(4.25e-13), .ps(2.2e-06), .pd(2.2e-06), .nrd(1), .nrs(1), .ng(1)) MN11 (SW1, SW_CLK, SW2, cds_globals.\gnd! );

endmodule
// Library - project_EACN_SESI, Cell - ADC_SAR, View - schematic
// LAST TIME SAVED: Mar 19 10:58:11 2026
// NETLIST TIME: Mar 19 10:59:38 2026

`worklib project_EACN_SESI
`view schematic

`timescale 1ns / 1ps
(* cds_ams_schematic *)

module ADC_SAR ( );
wire net5;
wire net18;
wire net17;
wire net1;
wire net4;
wire net16;
wire net15;
wire net3;
wire net13;
wire net12;
wire net10;
wire vin;
wire net9;
wire net2;
wire net8;
wire net7;
wire net23;
wire net11;
SWITCH I19 (.SW1(cds_globals.\gnd! ), .SW_CLK( net18 ), .SW2( net5 ));
SWITCH I17 (.SW1( net1 ), .SW_CLK( net17 ), .SW2( net5 ));
SWITCH I16 (.SW1( net1 ), .SW_CLK( net16 ), .SW2( net4 ));
SWITCH I14 (.SW1(cds_globals.\gnd! ), .SW_CLK( net15 ), .SW2( net4 ));
SWITCH I13 (.SW1( net1 ), .SW_CLK( net13 ), .SW2( net3 ));
SWITCH I11 (.SW1(cds_globals.\gnd! ), .SW_CLK( net12 ), .SW2( net3 ));
SWITCH I10 (.SW1( vin ), .SW_CLK( net10 ), .SW2( net1 ));
SWITCH I8 (.SW1(cds_globals.\gnd! ), .SW_CLK( net9 ), .SW2( net1 ));
SWITCH I5 (.SW1( net1 ), .SW_CLK( net8 ), .SW2( net2 ));
SWITCH I4 (.SW1(cds_globals.\gnd! ), .SW_CLK( net7 ), .SW2( net2 ));
control I20 (.q( net11 ), .d( net23 ), .en( net9 ));
INVX1 I24 (.Q( net10 ), .A( net9 ));
vsource #(.dc(2.24), .type("dc")) V5 (vin, cds_globals.\gnd! );
vsource #(.dc(2.24), .type("dc")) V2 (vref, cds_globals.\gnd! );
vsource #(.dc(1.12), .type("dc")) V1 (vcm, cds_globals.\gnd! );
vsource #(.dc(3.3), .type("dc")) V0 (cds_globals.\vdd! , cds_globals.\gnd! );
capacitor #(.c(cds_globals.Cu)) C3 (net19, net5);
capacitor #(.c(cds_globals.Cu)) C2 (net14, net4);
capacitor #(.c(2*cds_globals.Cu)) C1 (net11, net3);
capacitor #(.c(4*cds_globals.Cu)) C0 (net6, net2);
f_comp #(.outputHigh(3.3), .outputLow(0), .slope(1000)) X1 (net11, vcm, net22);
vsource #(.type("pulse"), .val0(0), .val1(3.3), .period(2e-06), .delay(1e-07), .rise(1e-10), .fall(1e-10), .width(1e-06)) V4 (net23, cds_globals.\gnd! );
vsource #(.type("pulse"), .val0(0), .val1(3.3), .period(1e-06), .delay(0), .rise(1e-10), .fall(1e-10), .width(5e-07)) V3 (net9, cds_globals.\gnd! );
resistor #(.r(10000)) R0 (net1, cds_globals.\gnd! );

endmodule
// Library - CORELIBD, Cell - INVX1, View - cmos_sch
// LAST TIME SAVED: Sep  5 11:28:01 2012
// NETLIST TIME: Mar 19 10:59:38 2026

`worklib CORELIBD
`view cmos_sch

`timescale 1ns / 1ps
(* cds_ams_schematic *)

module INVX1 (Q, A);
output  Q;
input  A;
wire (*
integer inh_conn_prop_name = "gnd";
integer inh_conn_def_value = "cds_globals.\\gnd! "; *)
\gnd! ;
wire (*
integer inh_conn_prop_name = "vdd";
integer inh_conn_def_value = "cds_globals.\\vdd! "; *)
\vdd! ;
modp #(.w(7e-07), .l(3.5e-07), .as(5.95e-13), .ad(5.95e-13), .ps(2.4e-06), .pd(2.4e-06), .nrd(0.7142857), .nrs(0.7142857), .ng(1)) M_i_1 (Q, A, \vdd! , \vdd! );
modn #(.w(4e-07), .l(3.5e-07), .as(3.4e-13), .ad(3.4e-13), .ps(2.1e-06), .pd(2.1e-06), .nrd(1.25), .nrs(1.25), .ng(1)) M_i_0 (Q, A, \gnd! , \gnd! );

endmodule
`noworklib
`noview
