// -----------------------------------------------------------------------------
// (c) Copyright 2010 Cadence Design Systems, Inc. All rights reserved worldwide.
// -----------------------------------------------------------------------------

// Binding AMSD Control Block for config project_EACN_SESI.ADC_SAR:config
// Created On: Mar 19 10:59:43 2026
// NOTE      : DO NOT change this system generated file.

amsd {
	config designtop="project_EACN_SESI.ADC_SAR:schematic"

	config cell="f_comp" view="analogtext"
	config cell="INVX1" lib="CORELIBD" view="cmos_sch"
	config cell="control" lib="project_EACN_SESI" view="behavioral"
	config cell="capacitor" view="analogtext"
	config cell="vsource" view="analogtext"
	config cell="resistor" view="analogtext"
	config cell="SWITCH" lib="project_EACN_SESI" view="schematic"
	config cell="modp" view="analogtext"
	config cell="modn" view="analogtext"

 }
