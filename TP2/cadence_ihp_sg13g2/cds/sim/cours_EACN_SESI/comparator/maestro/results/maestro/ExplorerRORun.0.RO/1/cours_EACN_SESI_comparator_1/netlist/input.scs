// PDK version:/users/soft/techno/dev/IHP/sg13/SG13G2_618_rev1.3.3/
// Design: cours_EACN_SESI/comparator
simulator lang=spectre
global 0 vdd!
parameters temperature=27 vd=0.01
include "$IHP_TECH/tech/SG13G2_HBT/VBIC/spectre/SG13G2_cornerBIP_vbic.scs" section=typ
include "$IHP_TECH/tech/SG13_MOS/library/spectreG2/cornerMOSlv_psp.scs" section=tt
include "$IHP_TECH/tech/SG13_MOS/library/spectreG2/cornerMOShv_psp.scs" section=tt
include "$IHP_TECH/tech/SG13G2_PASSIVES/spectre/SG13_cornerRES.scs" section=typ
include "$IHP_TECH/tech/SG13G2_PASSIVES/spectre/SG13_cornerCAP.scs" section=typ
include "$IHP_TECH/tech/SG13G2_PASSIVES/spectre/sg13g2_dschottky_nbl1_corner.scs" section=tt
include "$IHP_TECH/tech/SG13G2_PASSIVES/spectre/SG13_diodes.lib"
include "$IHP_TECH/tech/SG13_ESD/spectre/SG13_esd.lib"
include "$IHP_TECH/tech/SG13_PASSIVES/spectre/SG13_cornerTSV.scs" section=typ
include "$IHP_TECH/tech/SG13_PASSIVES/spectre/SG13_bondpad.lib"

// cours_EACN_SESI/comparator/schematic
N13 (net13 net3 0 0) sg13_lv_nmos w=500.0n l=500.0n ng=1 m=1
N5 (outp outn net6 0) sg13_lv_nmos w=2.000u l=500.0n ng=1 m=1
N4 (outn outp net6 0) sg13_lv_nmos w=2.000u l=500.0n ng=1 m=1
N3 (net3 net3 0 0) sg13_lv_nmos w=1.000u l=500.0n ng=1 m=1
N2 (net6 net3 0 0) sg13_lv_nmos w=1.000u l=500.0n ng=1 m=1
V4 (vdd! 0) vsource dc=1.2 type=dc
V3 (net2 0) vsource dc=0.6-vd/2 type=dc
V1 (outn 0) vsource dc=0.865-vd/2 type=dc
V0 (outp 0) vsource dc=0.865+vd/2 type=dc
V2 (net1 0) vsource dc=0.6+vd/2 type=dc
I8 (net16 net14) isource dc=5u type=dc
I7 (net15 net4) isource dc=5u type=dc
I4 (0 net3) isource dc=10u type=dc
R1 (net2 0) resistor r=100K
R0 (net1 0) resistor r=100K
P3 (net13 net13 vdd! vdd!) sg13_lv_pmos w=4.000u l=500.0n ng=1 m=1
P2 (outn net13 vdd! vdd!) sg13_lv_pmos w=4.000u l=500.0n ng=1 m=1
P1 (outp net13 vdd! vdd!) sg13_lv_pmos w=4.000u l=500.0n ng=1 m=1
I19 (0 outp) isource dc=0 type=pulse val0=0 val1=1n period=1 delay=0 rise=1n fall=1n width=5n
simulatorOptions options temp=27 ignorezerovar=yes
dcOp dc
save net4
saveOptions options currents=all subcktprobelvl=5 saveahdlvars=all
