ADE simulation setup
Run mode: Single Run, Sweeps and Corners
Tests:
  cours_EACN_SESI_comparator_1: cours_EACN_SESI/comparator/schematic, simulator spectre
    Variables: vd = 0.01
    Outputs: "/4"; "/net4"; /net4; /net6; /net5
