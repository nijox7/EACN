ADE simulation setup
Test cours_EACN_SESI_comparator_1: cours_EACN_SESI/comparator/schematic, simulator spectre
  Models: $IHP_TECH/tech/SG13G2_HBT/VBIC/spectre/SG13G2_cornerBIP_vbic.scs[typ], $IHP_TECH/tech/SG13_MOS/library/spectreG2/cornerMOSlv_psp.scs[tt], $IHP_TECH/tech/SG13_MOS/library/spectreG2/cornerMOShv_psp.scs[tt], $IHP_TECH/tech/SG13G2_PASSIVES/spectre/SG13_cornerRES.scs[typ], $IHP_TECH/tech/SG13G2_PASSIVES/spectre/SG13_cornerCAP.scs[typ], $IHP_TECH/tech/SG13G2_PASSIVES/spectre/sg13g2_dschottky_nbl1_corner.scs[tt], $IHP_TECH/tech/SG13G2_PASSIVES/spectre/SG13_diodes.lib, $IHP_TECH/tech/SG13_ESD/spectre/SG13_esd.lib, $IHP_TECH/tech/SG13_PASSIVES/spectre/SG13_cornerTSV.scs[typ], $IHP_TECH/tech/SG13_PASSIVES/spectre/SG13_bondpad.lib
  Variables: vd = 0.01
  Temperature: 27
  Simulator options: additionalArgs=ignorezerovar=yes
  Analysis dc: (saves the operating point)
  Analysis tran: stop=100n errpreset=conservative maxstep=0.11e-9 method=euler skipdc=yes ic=dev
  Signals: /net5, /net10, /net8
Run mode: Single Run, Sweeps and Corners
