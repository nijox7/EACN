ADE simulation setup
Run mode: Single Run, Sweeps and Corners
Tests:
  cours_EACN_SESI_bandgap_1: cours_EACN_SESI/bandgap/schematic, simulator spectre
    Variables: Vdc = 0; R2 = {Inclusion List}60k{Inclusion List}{From/To}Linear:60k:10k:90k{From/To}
