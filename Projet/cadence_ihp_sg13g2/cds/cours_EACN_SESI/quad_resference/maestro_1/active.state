ADE simulation setup
Test cours_EACN_SESI_quad_resference_1: cours_EACN_SESI/quad_resference/schematic, simulator spectre
  Models: $IHP_TECH/tech/SG13G2_HBT/VBIC/spectre/SG13G2_cornerBIP_vbic.scs[typ], $IHP_TECH/tech/SG13_MOS/library/spectreG2/cornerMOSlv_psp.scs[tt], $IHP_TECH/tech/SG13_MOS/library/spectreG2/cornerMOShv_psp.scs[tt], $IHP_TECH/tech/SG13G2_PASSIVES/spectre/SG13_cornerRES.scs[typ], $IHP_TECH/tech/SG13G2_PASSIVES/spectre/SG13_cornerCAP.scs[typ], $IHP_TECH/tech/SG13G2_PASSIVES/spectre/sg13g2_dschottky_nbl1_corner.scs[tt], $IHP_TECH/tech/SG13G2_PASSIVES/spectre/SG13_diodes.lib, $IHP_TECH/tech/SG13_ESD/spectre/SG13_esd.lib, $IHP_TECH/tech/SG13_PASSIVES/spectre/SG13_cornerTSV.scs[typ], $IHP_TECH/tech/SG13_PASSIVES/spectre/SG13_bondpad.lib
  Temperature: 27
  Simulator options: additionalArgs=ignorezerovar=yes
  Analysis dc: sweep /I8.dc start=0 stop=50u step=1u (saves the operating point)
  Output (IS("/I8/PLUS") / 4)
  Signals: /V0/MINUS (terminal), /I8/PLUS (terminal)
Run mode: Single Run, Sweeps and Corners
