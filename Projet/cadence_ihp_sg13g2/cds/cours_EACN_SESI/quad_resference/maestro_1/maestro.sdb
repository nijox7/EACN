ADE simulation setup
Run mode: Single Run, Sweeps and Corners
Tests:
  cours_EACN_SESI_quad_resference_1: cours_EACN_SESI/quad_resference/schematic, simulator spectre
    Outputs: nil; (IDC("/I8/PLUS") / 4); IDC("/I8/PLUS"); (I "/I8/PLUS"); IDC; (IS("/I8/MINUS") / 4); (IS("/I8/PLUS") / 4)
