ADE simulation setup
Run mode: Single Run, Sweeps and Corners
Tests:
  cours_EACN_SESI_quad_resference_1: cours_EACN_SESI/quad_resference/schematic, simulator spectre
    Variables: Vg = 0.6; vdd = 1.2
