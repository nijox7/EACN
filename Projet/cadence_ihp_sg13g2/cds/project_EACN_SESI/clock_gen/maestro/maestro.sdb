ADE simulation setup
Run mode: Single Run, Sweeps and Corners
Tests:
  project_EACN_SESI_clock_gen_1: project_EACN_SESI/clock_gen/schematic, simulator spectre
