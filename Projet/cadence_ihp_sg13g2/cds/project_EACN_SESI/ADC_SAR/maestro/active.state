ADE simulation setup
Test project_EACN_SESI_ADC_SAR_1: project_EACN_SESI/ADC_SAR/config, simulator ams
  Models: $IHP_TECH/tech/SG13G2_HBT/VBIC/spectre/SG13G2_cornerBIP_vbic.scs[typ], $IHP_TECH/tech/SG13_MOS/library/spectreG2/cornerMOSlv_psp.scs[tt], $IHP_TECH/tech/SG13_MOS/library/spectreG2/cornerMOShv_psp.scs[tt], $IHP_TECH/tech/SG13G2_PASSIVES/spectre/SG13_cornerRES.scs[typ], $IHP_TECH/tech/SG13G2_PASSIVES/spectre/SG13_cornerCAP.scs[typ], $IHP_TECH/tech/SG13G2_PASSIVES/spectre/sg13g2_dschottky_nbl1_corner.scs[tt], $IHP_TECH/tech/SG13G2_PASSIVES/spectre/SG13_diodes.lib, $IHP_TECH/tech/SG13_ESD/spectre/SG13_esd.lib, $IHP_TECH/tech/SG13_PASSIVES/spectre/SG13_cornerTSV.scs[typ], $IHP_TECH/tech/SG13_PASSIVES/spectre/SG13_bondpad.lib, /users/enseig/galayko/cours_EACN/projet/cadence_ihp_sg13g2/cds/allFunc.scs
  Variables: vin = 0.9; Cu = 200f
  Temperature: 27
  Simulator options: additionalArgs=ignorezerovar=yes
  Analysis tran: stop=3m
  Signals: /compin, /vin, /out<3:0>
Run mode: Single Run, Sweeps and Corners
