ADE simulation setup
Run mode: Single Run, Sweeps and Corners
Tests:
  project_EACN_SESI_ADC_SAR_1: project_EACN_SESI/ADC_SAR/config, simulator ams
    Variables: Cu = 200f; vin = 0.9
