ADE simulation setup
Run mode: Single Run, Sweeps and Corners
Tests:
  project_EACN_SESI_prof_comparator_test_students_1: project_EACN_SESI/comparator_test_students/schematic, simulator spectre
