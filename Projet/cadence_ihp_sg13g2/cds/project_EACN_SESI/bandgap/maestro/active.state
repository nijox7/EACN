ADE simulation setup
Test cours_EACN_SESI_bandgap_1: cours_EACN_SESI/bandgap/schematic, simulator spectre
  Models: $IHP_TECH/tech/SG13G2_HBT/VBIC/spectre/SG13G2_cornerBIP_vbic.scs[typ], $IHP_TECH/tech/SG13_MOS/library/spectreG2/cornerMOSlv_psp.scs[tt], $IHP_TECH/tech/SG13_MOS/library/spectreG2/cornerMOShv_psp.scs[tt], $IHP_TECH/tech/SG13G2_PASSIVES/spectre/SG13_cornerRES.scs[typ], $IHP_TECH/tech/SG13G2_PASSIVES/spectre/SG13_cornerCAP.scs[typ], $IHP_TECH/tech/SG13G2_PASSIVES/spectre/sg13g2_dschottky_nbl1_corner.scs[tt], $IHP_TECH/tech/SG13G2_PASSIVES/spectre/SG13_diodes.lib, $IHP_TECH/tech/SG13_ESD/spectre/SG13_esd.lib, $IHP_TECH/tech/SG13_PASSIVES/spectre/SG13_cornerTSV.scs[typ], $IHP_TECH/tech/SG13_PASSIVES/spectre/SG13_bondpad.lib, /users/enseig/galayko/cours_EACN/projet/cadence_ihp_sg13g2/cds/allFunc.scs
  Variables: Vdc = 0; R1 = 1000
  Temperature: 30
  Simulator options: additionalArgs=ignorezerovar=yes
  Analysis dc: sweep R1 start=100 stop=50 000 step=100 (saves the operating point)
  Signals: /vref
Run mode: Single Run, Sweeps and Corners
