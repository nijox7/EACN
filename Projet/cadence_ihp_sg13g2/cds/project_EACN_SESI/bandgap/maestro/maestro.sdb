ADE simulation setup
Run mode: Single Run, Sweeps and Corners
Tests:
  cours_EACN_SESI_bandgap_1: cours_EACN_SESI/bandgap/schematic, simulator spectre
    Variables: Vdc = 0; R1 = 1000
