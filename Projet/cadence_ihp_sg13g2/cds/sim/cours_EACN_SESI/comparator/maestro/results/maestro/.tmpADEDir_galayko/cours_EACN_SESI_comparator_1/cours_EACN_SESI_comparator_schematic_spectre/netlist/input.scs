// PDK version:/users/soft/techno/dev/IHP/sg13/SG13G2_618_rev1.3.3/
// Design: cours_EACN_SESI/comparator
simulator lang=spectre
global 0
parameters temperature=27 vd=0.01
include "$IHP_TECH/tech/SG13G2_HBT/VBIC/spectre/SG13G2_cornerBIP_vbic.scs" section=typ
include "$IHP_TECH/tech/SG13_MOS/library/spectreG2/cornerMOSlv_psp.scs" section=tt
include "$IHP_TECH/tech/SG13_MOS/library/spectreG2/cornerMOShv_psp.scs" section=tt
include "$IHP_TECH/tech/SG13G2_PASSIVES/spectre/SG13_cornerRES.scs" section=typ
include "$IHP_TECH/tech/SG13G2_PASSIVES/spectre/SG13_cornerCAP.scs" section=typ
include "$IHP_TECH/tech/SG13G2_PASSIVES/spectre/sg13g2_dschottky_nbl1_corner.scs" section=tt
include "$IHP_TECH/tech/SG13G2_PASSIVES/spectre/SG13_diodes.lib"
include "$IHP_TECH/tech/SG13_ESD/spectre/SG13_esd.lib"
include "$IHP_TECH/tech/SG13_PASSIVES/spectre/SG13_cornerTSV.scs" section=typ
include "$IHP_TECH/tech/SG13_PASSIVES/spectre/SG13_bondpad.lib"

// cours_EACN_SESI/comparator/schematic
N5 (vp vm net4 0) sg13_lv_nmos w=2.000u l=500.0n ng=1 m=1
N4 (vm vp net4 0) sg13_lv_nmos w=2.000u l=500.0n ng=1 m=1
N3 (net3 net3 0 0) sg13_lv_nmos w=1.000u l=500.0n ng=1 m=1
N2 (net4 net3 0 0) sg13_lv_nmos w=1.000u l=500.0n ng=1 m=1
V0 (net7 0) vsource dc=2+vd/2 type=dc
V1 (net5 0) vsource dc=2-vd/2 type=dc
V3 (net2 0) vsource dc=0.6-vd/2 type=dc
V2 (net1 0) vsource dc=0.6+vd/2 type=dc
I8 (0 vm) isource dc=5u type=dc
I7 (0 vp) isource dc=5u type=dc
I4 (0 net3) isource dc=10u type=dc
R1 (net2 0) resistor r=100K
R0 (net1 0) resistor r=100K
I23 (0 vp) isource type=pulse val0=-3u val1=3u period=1 delay=0 rise=10u fall=1n width=500.0m
I19 (0 vp) isource type=pulse val0=0 val1=1n period=1 delay=0 rise=1n fall=1n width=5n
simulatorOptions options temp=27 ignorezerovar=yes
dcOp dc
tran tran stop=10u errpreset=conservative maxstep=0.11e-9 ic=dev skipdc=yes linearic=yes method=euler
saveOptions options currents=all subcktprobelvl=5 saveahdlvars=all
