// Point Netlist Generated on: Apr  9 15:40:06 2026
// PDK version:/users/soft/techno/dev/IHP/sg13/SG13G2_618_rev1.3.3/
// Generated for: spectre
// Design Netlist Generated on: Apr  9 15:40:06 2026
// Design library name: cours_EACN_SESI
// Design cell name: bandgap
// Design view name: schematic
simulator lang=spectre
include "ade_e.scs"
global 0 sub! vdd!
parameters R2=60k Vdc=0
include "$IHP_TECH/tech/SG13G2_HBT/VBIC/spectre/SG13G2_cornerBIP_vbic.scs" section=typ
include "$IHP_TECH/tech/SG13_MOS/library/spectreG2/cornerMOSlv_psp.scs" section=tt
include "$IHP_TECH/tech/SG13_MOS/library/spectreG2/cornerMOShv_psp.scs" section=tt
include "$IHP_TECH/tech/SG13G2_PASSIVES/spectre/SG13_cornerRES.scs" section=typ
include "$IHP_TECH/tech/SG13G2_PASSIVES/spectre/SG13_cornerCAP.scs" section=typ
include "$IHP_TECH/tech/SG13G2_PASSIVES/spectre/sg13g2_dschottky_nbl1_corner.scs" section=tt
include "$IHP_TECH/tech/SG13G2_PASSIVES/spectre/SG13_diodes.lib"
include "$IHP_TECH/tech/SG13_ESD/spectre/SG13_esd.lib"
include "$IHP_TECH/tech/SG13_PASSIVES/spectre/SG13_cornerTSV.scs" section=typ
include "$IHP_TECH/tech/SG13_PASSIVES/spectre/SG13_bondpad.lib"
include "/users/enseig/galayko/cours_EACN/projet/cadence_ihp_sg13g2/cds/allFunc.scs"
include "netlist"
