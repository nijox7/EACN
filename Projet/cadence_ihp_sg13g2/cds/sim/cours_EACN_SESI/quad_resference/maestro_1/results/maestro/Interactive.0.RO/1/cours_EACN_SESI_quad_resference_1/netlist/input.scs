// PDK version:/users/soft/techno/dev/IHP/sg13/SG13G2_618_rev1.3.3/
// Design: cours_EACN_SESI/quad_resference
simulator lang=spectre
global 0 vdd!
parameters temperature=27
include "$IHP_TECH/tech/SG13G2_HBT/VBIC/spectre/SG13G2_cornerBIP_vbic.scs" section=typ
include "$IHP_TECH/tech/SG13_MOS/library/spectreG2/cornerMOSlv_psp.scs" section=tt
include "$IHP_TECH/tech/SG13_MOS/library/spectreG2/cornerMOShv_psp.scs" section=tt
include "$IHP_TECH/tech/SG13G2_PASSIVES/spectre/SG13_cornerRES.scs" section=typ
include "$IHP_TECH/tech/SG13G2_PASSIVES/spectre/SG13_cornerCAP.scs" section=typ
include "$IHP_TECH/tech/SG13G2_PASSIVES/spectre/sg13g2_dschottky_nbl1_corner.scs" section=tt
include "$IHP_TECH/tech/SG13G2_PASSIVES/spectre/SG13_diodes.lib"
include "$IHP_TECH/tech/SG13_ESD/spectre/SG13_esd.lib"
include "$IHP_TECH/tech/SG13_PASSIVES/spectre/SG13_cornerTSV.scs" section=typ
include "$IHP_TECH/tech/SG13_PASSIVES/spectre/SG13_bondpad.lib"

// cours_EACN_SESI/quad_resference/schematic
N2 (net4 net4 0 0) sg13_lv_nmos w=20.000u l=5.000u ng=4 m=1
N0 (net1 net1 net2 0) sg13_lv_nmos w=8.000u l=1.000u ng=1 m=1
N5 (A A 0 0) sg13_lv_nmos w=1.000u l=1.000u ng=1 m=1
N4 (B A net3 0) sg13_lv_nmos w=8.000u l=1.000u ng=1 m=1
N1 (net1 net1 0 0) sg13_lv_nmos w=1.000u l=1.000u ng=1 m=1
R1 (net2 0) resistor r=100K
R0 (net3 0) resistor r=100K
V2 (net4 0) vsource dc=600.0m type=dc
V1 (vdd! 0) vsource dc=1.2 type=dc
V0 (net1 0) vsource dc=600.0m type=dc
P1 (A B vdd! vdd!) sg13_lv_pmos w=3.000u l=1.000u ng=1 m=1
P0 (B B vdd! vdd!) sg13_lv_pmos w=3.000u l=1.000u ng=1 m=1
simulatorOptions options temp=27 ignorezerovar=yes
dcOp dc
dc dc dev=I8 param=dc start=0 stop=50u step=1u
save V0:p
saveOptions options currents=all subcktprobelvl=5 saveahdlvars=all
