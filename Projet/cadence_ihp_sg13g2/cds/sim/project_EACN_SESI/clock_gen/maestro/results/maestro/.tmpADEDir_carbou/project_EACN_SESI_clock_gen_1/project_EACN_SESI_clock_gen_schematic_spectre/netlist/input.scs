// PDK version:/users/soft/techno/dev/IHP/sg13/SG13G2_618_rev1.3.3/
// Design: project_EACN_SESI/clock_gen
simulator lang=spectre
global 0 vdd!
parameters temperature=27
include "$IHP_TECH/tech/SG13G2_HBT/VBIC/spectre/SG13G2_cornerBIP_vbic.scs" section=typ
include "$IHP_TECH/tech/SG13_MOS/library/spectreG2/cornerMOSlv_psp.scs" section=tt
include "$IHP_TECH/tech/SG13_MOS/library/spectreG2/cornerMOShv_psp.scs" section=tt
include "$IHP_TECH/tech/SG13G2_PASSIVES/spectre/SG13_cornerRES.scs" section=typ
include "$IHP_TECH/tech/SG13G2_PASSIVES/spectre/SG13_cornerCAP.scs" section=typ
include "$IHP_TECH/tech/SG13G2_PASSIVES/spectre/sg13g2_dschottky_nbl1_corner.scs" section=tt
include "$IHP_TECH/tech/SG13G2_PASSIVES/spectre/SG13_diodes.lib"
include "$IHP_TECH/tech/SG13_ESD/spectre/SG13_esd.lib"
include "$IHP_TECH/tech/SG13_PASSIVES/spectre/SG13_cornerTSV.scs" section=typ
include "$IHP_TECH/tech/SG13_PASSIVES/spectre/SG13_bondpad.lib"

// ixc013g2ng_stdcell/DFRRSQJIX1/schematic
subckt DFRRSQJIX1 Q C D RN SN inh_VDD inh_VSS
    N2 (Q SQIB inh_VSS inh_VSS) sg13_lv_nmos w=880.00n l=130.00n ng=1 m=1
    M0 (net061 SN inh_VSS inh_VSS) sg13_lv_nmos w=800.0n l=130.00n ng=1 m=1
    N1 (CI CIB inh_VSS inh_VSS) sg13_lv_nmos w=360.00n l=130.00n ng=1 m=1
    MN2 (MQIB CIB net51 inh_VSS) sg13_lv_nmos w=400.0n l=130.00n ng=1 m=1
    MN6 (MQI MQIB net061 inh_VSS) sg13_lv_nmos w=800.0n l=130.00n ng=1 m=1
    MN1 (net51 D net42 inh_VSS) sg13_lv_nmos w=400.0n l=130.00n ng=1 m=1
    MN8 (SQIB CI net56 inh_VSS) sg13_lv_nmos w=400.0n l=130.00n ng=1 m=1
    MN5 (MQIB CI net52 inh_VSS) sg13_lv_nmos w=300.0n l=130.00n ng=1 m=1
    MN11 (SQIB CIB net54 inh_VSS) sg13_lv_nmos w=300.0n l=130.00n ng=1 m=1
    MN10 (net54 SQI net47 inh_VSS) sg13_lv_nmos w=300.0n l=130.00n ng=1 m=1
    MN12 (SQI SQIB net060 inh_VSS) sg13_lv_nmos w=800.0n l=130.00n ng=1 m=1
    MN9 (net47 RN inh_VSS inh_VSS) sg13_lv_nmos w=640.00n l=130.00n ng=1 m=1
    MN7 (net56 MQI net47 inh_VSS) sg13_lv_nmos w=400.0n l=130.00n ng=1 m=1
    MN3 (net42 RN inh_VSS inh_VSS) sg13_lv_nmos w=600.0n l=130.00n ng=1 m=1
    MN4 (net52 MQI net42 inh_VSS) sg13_lv_nmos w=300.0n l=130.00n ng=1 m=1
    M3 (net060 SN inh_VSS inh_VSS) sg13_lv_nmos w=800.0n l=130.00n ng=1 m=1
    N0 (CIB C inh_VSS inh_VSS) sg13_lv_nmos w=360.00n l=130.00n ng=1 m=1
    P2 (Q SQIB inh_VDD inh_VDD) sg13_lv_pmos w=1.335u l=130.00n ng=1 m=1
    P1 (CI CIB inh_VDD inh_VDD) sg13_lv_pmos w=550.00n l=130.00n ng=1 m=1
    P0 (CIB C inh_VDD inh_VDD) sg13_lv_pmos w=550.00n l=130.00n ng=1 m=1
    M1 (MQI SN inh_VDD inh_VDD) sg13_lv_pmos w=670.00n l=130.00n ng=1 m=1
    MP3 (MQIB RN inh_VDD inh_VDD) sg13_lv_pmos w=300.0n l=130.00n ng=1 m=1
    MP1 (MQIB CI net57 inh_VDD) sg13_lv_pmos w=690.00n l=130.00n ng=1 m=1
    MP9 (SQIB RN inh_VDD inh_VDD) sg13_lv_pmos w=300.0n l=130.00n ng=1 m=1
    MP6 (MQI MQIB inh_VDD inh_VDD) sg13_lv_pmos w=670.00n l=130.00n ng=1 m=1
    MP8 (net55 MQI inh_VDD inh_VDD) sg13_lv_pmos w=610.00n l=130.00n ng=1 m=1
    M2 (SQI SN inh_VDD inh_VDD) sg13_lv_pmos w=670.00n l=130.00n ng=1 m=1
    MP2 (net57 D inh_VDD inh_VDD) sg13_lv_pmos w=690.00n l=130.00n ng=1 m=1
    MP12 (SQI SQIB inh_VDD inh_VDD) sg13_lv_pmos w=670.00n l=130.00n ng=1 m=1
    MP11 (net58 SQI inh_VDD inh_VDD) sg13_lv_pmos w=300.0n l=130.00n ng=1 m=1
    MP10 (SQIB CI net58 inh_VDD) sg13_lv_pmos w=300.0n l=130.00n ng=1 m=1
    MP4 (MQIB CIB net53 inh_VDD) sg13_lv_pmos w=300.0n l=130.00n ng=1 m=1
    MP7 (SQIB CIB net55 inh_VDD) sg13_lv_pmos w=610.00n l=130.00n ng=1 m=1
    MP5 (net53 MQI inh_VDD inh_VDD) sg13_lv_pmos w=300.0n l=130.00n ng=1 m=1
ends DFRRSQJIX1

// ixc013g2ng_stdcell/INVJIX0/schematic
subckt INVJIX0 Q A inh_VDD inh_VSS
    MN1 (Q A inh_VSS inh_VSS) sg13_lv_nmos w=440.00n l=130.00n ng=1 m=1
    MP1 (Q A inh_VDD inh_VDD) sg13_lv_pmos w=670.00n l=130.00n ng=1 m=1
ends INVJIX0

// project_EACN_SESI/clock_gen/schematic
I13 (vdd! net7) isource dc=100.0n type=dc
C0 (net7 0) capacitor c=75f
N1 (net7 net13 0 0) sg13_lv_nmos w=1.000u l=130.00n ng=1 m=1
I35 (out net1 net12 vdd! vdd! vdd! 0) DFRRSQJIX1
I16 (net11 0 0 net7 net8 vdd! 0) DFRRSQJIX1
I36 (net12 out vdd! 0) INVJIX0
I34 (net8 net7 vdd! 0) INVJIX0
I29 (net13 net10 vdd! 0) INVJIX0
I28 (net10 net1 vdd! 0) INVJIX0
I27 (net1 net4 vdd! 0) INVJIX0
I25 (net4 net11 vdd! 0) INVJIX0
V0 (vdd! 0) vsource dc=1.2 type=dc
simulatorOptions options temp=27 ignorezerovar=yes
tran tran stop=10u errpreset=conservative ic=dev skipdc=yes
saveOptions options currents=all subcktprobelvl=5 saveahdlvars=all
