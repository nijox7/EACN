// PDK version:/users/soft/techno/dev/IHP/sg13/SG13G2_618_rev1.3.3/
// Design: cours_EACN_SESI/bandgap
simulator lang=spectre
global 0 sub! vdd!
parameters temperature=30 Vdc=0 R1=1000
include "$IHP_TECH/tech/SG13G2_HBT/VBIC/spectre/SG13G2_cornerBIP_vbic.scs" section=typ
include "$IHP_TECH/tech/SG13_MOS/library/spectreG2/cornerMOSlv_psp.scs" section=tt
include "$IHP_TECH/tech/SG13_MOS/library/spectreG2/cornerMOShv_psp.scs" section=tt
include "$IHP_TECH/tech/SG13G2_PASSIVES/spectre/SG13_cornerRES.scs" section=typ
include "$IHP_TECH/tech/SG13G2_PASSIVES/spectre/SG13_cornerCAP.scs" section=typ
include "$IHP_TECH/tech/SG13G2_PASSIVES/spectre/sg13g2_dschottky_nbl1_corner.scs" section=tt
include "$IHP_TECH/tech/SG13G2_PASSIVES/spectre/SG13_diodes.lib"
include "$IHP_TECH/tech/SG13_ESD/spectre/SG13_esd.lib"
include "$IHP_TECH/tech/SG13_PASSIVES/spectre/SG13_cornerTSV.scs" section=typ
include "$IHP_TECH/tech/SG13_PASSIVES/spectre/SG13_bondpad.lib"
include "/users/enseig/galayko/cours_EACN/projet/cadence_ihp_sg13g2/cds/allFunc.scs"

// cours_EACN_SESI/bandgap/schematic
R4 (net6 net1) resistor r=5K
R3 (net3 0) resistor r=75K
R2 (net5 0) resistor r=75K
R1 (vref 0) resistor r=R1
R0 (net3 net8) resistor r=5K
V7 (net12 net6) vsource dc=0 type=dc
V6 (net7 net2) vsource dc=0 type=dc
V5 (net11 net3) vsource dc=0 type=dc
V4 (net10 net5) vsource dc=0 type=dc
V2 (sub! 0) vsource dc=0 type=dc
V1 (vdd! 0) vsource dc=1.2 type=dc
D9 (net1 0 0) pnpMPA a=40p p=44u ac=76.254p pc=49.76u m=1
D8 (net1 0 0) pnpMPA a=40p p=44u ac=76.254p pc=49.76u m=1
D7 (net1 0 0) pnpMPA a=40p p=44u ac=76.254p pc=49.76u m=1
D6 (net1 0 0) pnpMPA a=40p p=44u ac=76.254p pc=49.76u m=1
D5 (net2 0 0) pnpMPA a=40p p=44u ac=76.254p pc=49.76u m=1
D4 (net8 0 0) pnpMPA a=40p p=44u ac=76.254p pc=49.76u m=1
D3 (net8 0 0) pnpMPA a=40p p=44u ac=76.254p pc=49.76u m=1
D2 (net8 0 0) pnpMPA a=40p p=44u ac=76.254p pc=49.76u m=1
D1 (net8 0 0) pnpMPA a=40p p=44u ac=76.254p pc=49.76u m=1
D0 (net5 0 0) pnpMPA a=40p p=44u ac=76.254p pc=49.76u m=1
P2 (vref net9 vdd! vdd!) sg13_lv_pmos w=10.000u l=500.0n ng=1 m=1
P1 (net10 net9 vdd! vdd!) sg13_lv_pmos w=10.000u l=500.0n ng=1 m=1
P0 (net11 net9 vdd! vdd!) sg13_lv_pmos w=10.000u l=500.0n ng=1 m=1
E0 (net9 0 net11 net10) vcvs gain=1000
simulatorOptions options temp=30 ignorezerovar=yes
dcOp dc
dc dc param=R1 start=1000 stop=50000 step=100
save vref
saveOptions options currents=all subcktprobelvl=5 saveahdlvars=all
