// AMS netlist generated by the AMS Unified netlister
// IC subversion:  IC23.1-64b.ISR12.37
// Xcelium version: 23.03-s013
// Copyright(C) 2005-2009, Cadence Design Systems, Inc
// User: galayko Pid: 637184
// Design library name: project_EACN_SESI
// Design cell name: ADC_SAR
// Design view name: config
// Solver: Spectre

`include "disciplines.vams"
`include "userDisciplines.vams"
// HDL file - ixc013g2ng_stdcell, INVJIX1, functional.
// HDL file - project_EACN_SESI, control, behavioral.
// HDL file - ixc013g2ng_stdcell, INVJIX0, functional.
// Library - project_EACN_SESI, Cell - SWITCH, View - schematic
// LAST TIME SAVED: Apr  2 09:45:15 2026
// NETLIST TIME: Apr  2 09:48:12 2026

`worklib project_EACN_SESI
`view schematic

`timescale 1ns / 1ns
(* cds_ams_schematic *)

module SWITCH (SW1, SW2, SW_CLK);
input  SW_CLK;
inout  SW1, SW2;
wire net04;
INVJIX0 I39 (.Q( net04 ), .A( SW_CLK ));
sg13_lv_nmos #(.w(5e-07), .l(3.5e-07), .ng(1), .ad(4.25e-13), .as(4.25e-13), .pd(2.2e-06), .ps(2.2e-06), .m(1))
(* integer passed_mfactor = "m"; *)
 MN11 (SW1, SW_CLK, SW2, cds_globals.\gnd! );
sg13_lv_pmos #(.w(1e-06), .l(3.5e-07), .ng(1), .ad(8.5e-13), .as(8.5e-13), .pd(2.7e-06), .ps(2.7e-06), .m(1))
(* integer passed_mfactor = "m"; *)
 MP5 (SW2, net04, SW1, cds_globals.\vdd! );

endmodule
// Library - project_EACN_SESI, Cell - ADC_SAR, View - schematic
// LAST TIME SAVED: Apr  2 09:43:17 2026
// NETLIST TIME: Apr  2 09:48:12 2026

`worklib project_EACN_SESI
`view schematic

`timescale 1ns / 1ns
(* cds_ams_schematic *)

module ADC_SAR ( );
wire vcm;
wire vsw1;
wire net6;
wire net5;
wire vswc;
wire net17;
wire net1;
wire net4;
wire net16;
wire vswc0;
wire net3;
wire net13;
wire vswc1;
wire net10;
wire net20;
wire vsw2;
wire vref;
wire net2;
wire net8;
wire vswc2;
wire net21;
wire net23;
wire net24;
wire net7;
SWITCH I34 (.SW1( net6 ), .SW_CLK( vsw1 ), .SW2( vcm ));
SWITCH I19 (.SW1( vcm ), .SW_CLK( vswc ), .SW2( net5 ));
SWITCH I17 (.SW1( net1 ), .SW_CLK( net17 ), .SW2( net5 ));
SWITCH I16 (.SW1( net1 ), .SW_CLK( net16 ), .SW2( net4 ));
SWITCH I14 (.SW1( vcm ), .SW_CLK( vswc0 ), .SW2( net4 ));
SWITCH I13 (.SW1( net1 ), .SW_CLK( net13 ), .SW2( net3 ));
SWITCH I11 (.SW1( vcm ), .SW_CLK( vswc1 ), .SW2( net3 ));
SWITCH I10 (.SW1( net20 ), .SW_CLK( net10 ), .SW2( net1 ));
SWITCH I8 (.SW1( vref ), .SW_CLK( vsw2 ), .SW2( net1 ));
SWITCH I5 (.SW1( net1 ), .SW_CLK( net8 ), .SW2( net2 ));
SWITCH I4 (.SW1( vcm ), .SW_CLK( vswc2 ), .SW2( net2 ));
control I29 (.q( net24 ), .d( net23 ), .en( net21 ));
INVJIX1 I35 (.A( vswc0 ), .Q( net16 ));
INVJIX1 I30 (.Q( net8 ), .A( vswc2 ));
INVJIX1 I37 (.A( vswc ), .Q( net7 ));
INVJIX1 I31 (.Q( net13 ), .A( vswc1 ));
INVJIX1 I36 (.A( vswc ), .Q( net17 ));
INVJIX1 I38 (.A( vsw2 ), .Q( net10 ));
vsource #(.dc(1), .type("dc")) V5 (vin, cds_globals.\gnd! );
vsource #(.dc(2.24), .type("dc")) V2 (vref, cds_globals.\gnd! );
vsource #(.dc(1.12), .type("dc")) V1 (vcm, cds_globals.\gnd! );
vsource #(.dc(3.3), .type("dc")) V0 (cds_globals.\vdd! , cds_globals.\gnd! );
capacitor #(.c(cds_globals.Cu)) C (net6, net5);
capacitor #(.c(cds_globals.Cu)) C0 (net6, net4);
capacitor #(.c(2*cds_globals.Cu)) C1 (net6, net3);
capacitor #(.c(4*cds_globals.Cu)) C2 (net6, net2);
f_comp #(.outputHigh(3.3), .outputLow(0), .slope(1000)) X1 (net6, vcm, net22);
vsource #(.type("pulse"), .val0(0), .val1(3.3), .period(1e-06), .delay(0), .rise(1e-10), .fall(1e-10), .width(5e-07)) V7 (net21, cds_globals.\gnd! );
vsource #(.type("pulse"), .val0(0), .val1(3.3), .period(2e-06), .delay(1e-07), .rise(1e-10), .fall(1e-10), .width(1e-06)) V6 (net23, cds_globals.\gnd! );

endmodule
`noworklib
`noview
