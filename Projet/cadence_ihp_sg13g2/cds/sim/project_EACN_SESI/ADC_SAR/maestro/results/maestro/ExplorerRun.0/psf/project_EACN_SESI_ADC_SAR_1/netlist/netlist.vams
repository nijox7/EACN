// AMS netlist generated by the AMS Unified netlister
// IC subversion:  IC23.1-64b.ISR12.37
// Xcelium version: 23.03-s013
// Copyright(C) 2005-2009, Cadence Design Systems, Inc
// User: carbou Pid: 2372617
// Design library name: project_EACN_SESI
// Design cell name: ADC_SAR
// Design view name: config
// Solver: Spectre

`include "disciplines.vams"
`include "userDisciplines.vams"
// HDL file - ixc013g2ng_stdcell, INVJIX1, functional.
// HDL file - ixc013g2ng_stdcell, INVJIX0, functional.
// HDL file - project_EACN_SESI, SAR_control, behavioral.
// Library - project_EACN_SESI, Cell - buf_eq_delay, View - schematic
// LAST TIME SAVED: Apr 14 18:47:37 2026
// NETLIST TIME: Apr 16 17:28:55 2026

`worklib project_EACN_SESI
`view schematic

`timescale 1ns / 1ns
(* cds_ams_schematic *)

module buf_eq_delay (Q, A);
output  Q;
input  A;
wire (*
integer inh_conn_prop_name = "VSS";
integer inh_conn_def_value = "cds_globals.\\VSS! "; *)
\VSS! ;
wire (*
integer inh_conn_prop_name = "VDD";
integer inh_conn_def_value = "cds_globals.\\VDD! "; *)
\VDD! ;
sg13_lv_nmos #(.w(8.8e-07), .l(1.3e-07), .ng(1), .ad(0), .as(0), .pd(0), .ps(0), .m(1))
(* integer passed_mfactor = "m"; *)
 N0 (A, \VDD! , Q, \VSS! );
sg13_lv_pmos #(.w(1.34e-06), .l(1.3e-07), .ng(1), .ad(0), .as(0), .pd(0), .ps(0), .m(1))
(* integer passed_mfactor = "m"; *)
 P0 (A, \VSS! , Q, \VDD! );

endmodule
// Library - project_EACN_SESI, Cell - SWITCH, View - schematic
// LAST TIME SAVED: Apr  2 09:45:15 2026
// NETLIST TIME: Apr 16 17:28:55 2026

`worklib project_EACN_SESI
`view schematic

`timescale 1ns / 1ns
(* cds_ams_schematic *)

module SWITCH (SW1, SW2, SW_CLK);
input  SW_CLK;
inout  SW1, SW2;
wire net04;
INVJIX0 I39 (.Q( net04 ), .A( SW_CLK ));
sg13_lv_nmos #(.w(5e-07), .l(3.5e-07), .ng(1), .ad(4.25e-13), .as(4.25e-13), .pd(2.2e-06), .ps(2.2e-06), .m(1))
(* integer passed_mfactor = "m"; *)
 MN11 (SW1, SW_CLK, SW2, cds_globals.\gnd! );
sg13_lv_pmos #(.w(1e-06), .l(3.5e-07), .ng(1), .ad(8.5e-13), .as(8.5e-13), .pd(2.7e-06), .ps(2.7e-06), .m(1))
(* integer passed_mfactor = "m"; *)
 MP5 (SW2, net04, SW1, cds_globals.\vdd! );

endmodule
// Library - project_EACN_SESI, Cell - ADC_SAR, View - schematic
// LAST TIME SAVED: Apr 16 17:28:47 2026
// NETLIST TIME: Apr 16 17:28:55 2026

`worklib project_EACN_SESI
`view schematic

`timescale 1ns / 1ns
(* cds_ams_schematic *)

module ADC_SAR ( );
wire [3:0] out;
wire comp;
wire vsw1;
wire vsw2;
wire vswC;
wire vswC0;
wire vswC1;
wire vswC2;
wire vswC3;
wire CLK;
wire net16;
wire net15;
wire net14;
wire net11;
wire net7;
wire net2;
wire vcm;
wire compin;
wire net5;
wire net9;
wire a;
wire net4;
wire vbc3;
wire net1;
wire net10;
wire net3;
wire net8;
wire vref;
wire net12;
wire vin;
wire vbc2;
wire net6;
SAR_control I43 (.cout( out ), .clk( CLK ), .vswc3( vswC3 ), .vswc2( vswC2 ), .vswc1( vswC1 ), .vswc0( vswC0 ), .vswc( vswC ), .vsw2( vsw2 ), .vsw1( vsw1 ), .comp( comp ));
buf_eq_delay I68 (.A( vsw2 ), .Q( net16 ));
buf_eq_delay I67 (.A( vswC ), .Q( net15 ));
buf_eq_delay I66 (.A( vswC0 ), .Q( net14 ));
buf_eq_delay I65 (.A( vswC1 ), .Q( net11 ));
buf_eq_delay I57 (.A( vswC3 ), .Q( net7 ));
buf_eq_delay I56 (.A( vswC2 ), .Q( net2 ));
SWITCH I34 (.SW1( compin ), .SW_CLK( vsw1 ), .SW2( vcm ));
SWITCH I19 (.SW1(cds_globals.\gnd! ), .SW_CLK( net9 ), .SW2( net5 ));
SWITCH I17 (.SW1( a ), .SW_CLK( net15 ), .SW2( net5 ));
SWITCH I16 (.SW1( a ), .SW_CLK( net14 ), .SW2( net4 ));
SWITCH I40 (.SW1(cds_globals.\gnd! ), .SW_CLK( net1 ), .SW2( vbc3 ));
SWITCH I14 (.SW1(cds_globals.\gnd! ), .SW_CLK( net10 ), .SW2( net4 ));
SWITCH I13 (.SW1( a ), .SW_CLK( net11 ), .SW2( net3 ));
SWITCH I11 (.SW1(cds_globals.\gnd! ), .SW_CLK( net8 ), .SW2( net3 ));
SWITCH I10 (.SW1( vref ), .SW_CLK( net16 ), .SW2( a ));
SWITCH I8 (.SW1( vin ), .SW_CLK( net12 ), .SW2( a ));
SWITCH I5 (.SW1( a ), .SW_CLK( net2 ), .SW2( vbc2 ));
SWITCH I41 (.SW1( a ), .SW_CLK( net7 ), .SW2( vbc3 ));
SWITCH I4 (.SW1(cds_globals.\gnd! ), .SW_CLK( net6 ), .SW2( vbc2 ));
INVJIX1 I45 (.A( vswC3 ), .Q( net1 ));
INVJIX1 I49 (.A( vswC ), .Q( net9 ));
INVJIX1 I47 (.A( vswC1 ), .Q( net8 ));
INVJIX1 I46 (.A( vswC2 ), .Q( net6 ));
INVJIX1 I48 (.A( vswC0 ), .Q( net10 ));
INVJIX1 I50 (.A( vsw2 ), .Q( net12 ));
vsource #(.dc(cds_globals.vin), .type("dc")) V5 (net20, cds_globals.\gnd! );
vsource #(.dc(1), .type("dc")) V2 (vref, cds_globals.\gnd! );
vsource #(.dc(0.5), .type("dc")) V1 (vcm, cds_globals.\gnd! );
vsource #(.dc(1.2), .type("dc")) V0 (cds_globals.\vdd! , cds_globals.\gnd! );
capacitor #(.c(cds_globals.Cu)) C (compin, net5);
capacitor #(.c(cds_globals.Cu)) C0 (compin, net4);
capacitor #(.c(8*cds_globals.Cu)) C4 (compin, vbc3);
capacitor #(.c(2*cds_globals.Cu)) C1 (compin, net3);
capacitor #(.c(4*cds_globals.Cu)) C2 (compin, vbc2);
f_comp #(.outputHigh(1.2), .outputLow(0), .slope(10000)) X3 (compin, vcm, comp);
vsource #(.type("pulse"), .val0(0), .val1(1), .period(1), .delay(5e-05), .rise(0.003), .fall(0.001), .width(0.5)) V10 (vin, cds_globals.\gnd! );
vsource #(.type("pulse"), .val0(0), .val1(1.2), .period(1e-05), .delay(0), .rise(1e-09), .fall(1e-09), .width(5e-06)) V8 (CLK, cds_globals.\gnd! );

endmodule
`noworklib
`noview
