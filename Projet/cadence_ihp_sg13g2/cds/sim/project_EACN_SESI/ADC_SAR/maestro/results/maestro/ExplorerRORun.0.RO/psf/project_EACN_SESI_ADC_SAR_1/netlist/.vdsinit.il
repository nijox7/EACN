(envSetVal "asimenv.startup" "projectDir" 'string "./sim")
(envSetVal "maestro.lscs" "startEvaluatorAfterSimFinish" 'boolean nil)
(envSetVal "maestro.lscs" "evaluateMultipleMonteCarlo" 'boolean t)
(envSetVal "adexl.results" "evalOutputsOnSimFailure" 'cyclic "SkipFailedAnalyses")
