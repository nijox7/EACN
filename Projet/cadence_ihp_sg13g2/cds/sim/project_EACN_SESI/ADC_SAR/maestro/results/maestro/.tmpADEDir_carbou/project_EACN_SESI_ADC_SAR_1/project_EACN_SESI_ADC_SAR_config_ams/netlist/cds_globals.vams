// Verilog-AMS cds_globals module for top-level cell:
//    project_EACN_SESI/ADC_SAR.
// Generated by ADE.
// Cadence Design Systems, Inc.

// This is an autoGenerated file, any changes done to this file may get lost.

`include "disciplines.vams"
`include "userDisciplines.vams"

module cds_globals;

// Global Signals
   wire \VSS! ;
   wire \VDD! ;
   wire \vdd! ;
   electrical \gnd! ;
   ground \gnd! ;

// Design Variables
   dynamicparam real temperature = 27;
   dynamicparam real vin = 0.9;
   dynamicparam real Cu = 200f;

endmodule
